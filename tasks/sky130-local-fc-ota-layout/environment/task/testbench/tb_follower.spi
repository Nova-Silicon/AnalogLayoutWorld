* Diagnostic characterization
.lib "/opt/analog-layout/pdks/sky130/sky130A/libs.tech/combined/continuous/sky130.lib.spice" tt
.include "dut.spice"
.option scale=1e-6
.temp 27
VDD vdd 0 1.8
IREF vdd ibias 1e-05
VIN stim 0 PULSE(0.8 1.0 1u 10n 10n 2u 4u)
XDUT stim out out ibias vdd 0 folded_cascode_ota
CLOAD out 0 2e-12
.control
set num_threads=1
tran 1n 8u
meas tran output_low FIND v(out) AT=.9u
meas tran output_high FIND v(out) AT=2.9u
meas tran vmax MAX v(out) FROM=1u TO=3u
meas tran vmin MIN v(out) FROM=3u TO=5u
meas tran rise_dt TRIG v(out) VAL=0.8200000000000001 RISE=1 TARG v(out) VAL=0.98 RISE=1
meas tran fall_dt TRIG v(out) VAL=0.98 FALL=1 TARG v(out) VAL=0.8200000000000001 FALL=1
meas tran settle_high FIND v(out) AT=1.5u
meas tran settle_low FIND v(out) AT=3.5u
quit
.endc

.end
