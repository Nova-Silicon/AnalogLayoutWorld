* Mechanically normalized from Ying Haochi's completed Virtuoso hierarchy.
.subckt charge_pump_regulated AVDD AVSS CLK EN IBN1U VOUT
XMNM8 ICTR AMP_VN net030 AVSS sky130_fd_pr__nfet_01v8 w=1 l=0.6 as=0.265 ad=0.14 ps=2.53 pd=1.28 m=4 mult=4
XMNM7 net028 AMP_VP net030 AVSS sky130_fd_pr__nfet_01v8 w=1 l=0.6 as=0.265 ad=0.14 ps=2.53 pd=1.28 m=4 mult=4
XMNM6 net030 IBN1U AVSS AVSS sky130_fd_pr__nfet_01v8 w=0.8 l=0.3 as=0.212 ad=0.212 ps=2.13 pd=2.13 m=1 mult=1
XMNM5 IBN1U IBN1U AVSS AVSS sky130_fd_pr__nfet_01v8 w=0.8 l=0.3 as=0.212 ad=0.212 ps=2.13 pd=2.13 m=1 mult=1
XMNM9 IBN1U ENB AVSS AVSS sky130_fd_pr__nfet_01v8 w=1 l=0.6 as=0.265 ad=0.265 ps=2.53 pd=2.53 m=1 mult=1
XMNM10 net025 EN AVSS AVSS sky130_fd_pr__nfet_01v8 w=10 l=0.2 as=2.65 ad=1.4 ps=20.53 pd=10.28 m=2 mult=2
XMNM11 net024 EN AVSS AVSS sky130_fd_pr__nfet_01v8 w=10 l=0.2 as=2.65 ad=1.4 ps=20.53 pd=10.28 m=2 mult=2
XI7 EN AVDD AVSS ENB IVD2A
XMPM3 ICTR net028 AVDD AVDD sky130_fd_pr__pfet_01v8 w=1 l=3 as=0.265 ad=0.14 ps=2.53 pd=1.28 m=4 mult=4
XMPM2 net028 net028 AVDD AVDD sky130_fd_pr__pfet_01v8 w=1 l=3 as=0.265 ad=0.14 ps=2.53 pd=1.28 m=4 mult=4
XMPM4 net028 EN AVDD AVDD sky130_fd_pr__pfet_01v8 w=1 l=0.6 as=0.265 ad=0.265 ps=2.53 pd=2.53 m=1 mult=1
XI6 AVDD AVSS CLK EN ICTR VOUT charge_pump_regulated_core
XR3 AVDD AMP_VN AVSS sky130_fd_pr__res_xhigh_po_0p69 l=50
XR2 AMP_VN net025 AVSS sky130_fd_pr__res_xhigh_po_0p69 l=50
XR1 AMP_VP net024 AVSS sky130_fd_pr__res_xhigh_po_0p69 l=50
XR0 VOUT AMP_VP AVSS sky130_fd_pr__res_xhigh_po_0p69 l=80
.ends charge_pump_regulated

.subckt IVD2A A VDD VSS Y
Xmp0 Y A VDD VDD sky130_fd_pr__pfet_01v8 w=1.13 l=0.15 as=0.29945 ad=0.1582 ps=2.79 pd=1.41 m=2 mult=2
Xmn0 Y A VSS VSS sky130_fd_pr__nfet_01v8 w=0.76 l=0.15 as=0.2014 ad=0.1064 ps=2.05 pd=1.04 m=2 mult=2
.ends IVD2A

.subckt IVD4A A VDD VSS Y
Xmp0 Y A VDD VDD sky130_fd_pr__pfet_01v8 w=1.13 l=0.2 as=0.228825 ad=0.1582 ps=2.1 pd=1.41 m=4 mult=4
Xmn0 Y A VSS VSS sky130_fd_pr__nfet_01v8 w=0.76 l=0.2 as=0.1539 ad=0.1064 ps=1.545 pd=1.04 m=4 mult=4
.ends IVD4A

.subckt ND2D1A A B VDD VSS Y
Xmn1 Y B n0 VSS sky130_fd_pr__nfet_01v8 w=0.76 l=0.2 as=0.2014 ad=0.2014 ps=2.05 pd=2.05 m=1 mult=1
Xmn0 n0 A VSS VSS sky130_fd_pr__nfet_01v8 w=0.76 l=0.2 as=0.2014 ad=0.2014 ps=2.05 pd=2.05 m=1 mult=1
Xmp1 Y B VDD VDD sky130_fd_pr__pfet_01v8 w=1.13 l=0.2 as=0.29945 ad=0.29945 ps=2.79 pd=2.79 m=1 mult=1
Xmp0 Y A VDD VDD sky130_fd_pr__pfet_01v8 w=1.13 l=0.2 as=0.29945 ad=0.29945 ps=2.79 pd=2.79 m=1 mult=1
.ends ND2D1A

.subckt charge_pump_regulated_core AVDD AVSS CLK EN ICTR VOUT
XMNM2 net23 net26 AVSS AVSS sky130_fd_pr__nfet_01v8 w=0.76 l=0.2 as=0.138067 ad=0.1064 ps=1.37667 pd=1.04 m=6 mult=6
Xmn0 net19 net06 AVSS AVSS sky130_fd_pr__nfet_01v8 w=0.76 l=0.2 as=0.138067 ad=0.1064 ps=1.37667 pd=1.04 m=6 mult=6
XI4 net06 AVDD AVSS net26 IVD4A
XI3 net011 AVDD AVSS net06 IVD4A
CC1__unit1 net018 net23 sky130_fd_pr__model__cap_mim a=625 p=100
CC1__unit2 net018 net23 sky130_fd_pr__model__cap_mim a=625 p=100
CC1__unit3 net018 net23 sky130_fd_pr__model__cap_mim a=625 p=100
CC1__unit4 net018 net23 sky130_fd_pr__model__cap_mim a=625 p=100
CC1__unit5 net018 net23 sky130_fd_pr__model__cap_mim a=625 p=100
CC1__unit6 net018 net23 sky130_fd_pr__model__cap_mim a=625 p=100
CC1__unit7 net018 net23 sky130_fd_pr__model__cap_mim a=625 p=100
CC1__unit8 net018 net23 sky130_fd_pr__model__cap_mim a=625 p=100
CC1__unit9 net018 net23 sky130_fd_pr__model__cap_mim a=625 p=100
CC1__unit10 net018 net23 sky130_fd_pr__model__cap_mim a=625 p=100
CC1__unit11 net018 net23 sky130_fd_pr__model__cap_mim a=625 p=100
CC1__unit12 net018 net23 sky130_fd_pr__model__cap_mim a=625 p=100
CC1__unit13 net018 net23 sky130_fd_pr__model__cap_mim a=625 p=100
CC1__unit14 net018 net23 sky130_fd_pr__model__cap_mim a=625 p=100
CC1__unit15 net018 net23 sky130_fd_pr__model__cap_mim a=625 p=100
CC1__unit16 net018 net23 sky130_fd_pr__model__cap_mim a=625 p=100
CC1__unit17 net018 net23 sky130_fd_pr__model__cap_mim a=625 p=100
CC1__unit18 net018 net23 sky130_fd_pr__model__cap_mim a=625 p=100
CC1__unit19 net018 net23 sky130_fd_pr__model__cap_mim a=625 p=100
CC1__unit20 net018 net23 sky130_fd_pr__model__cap_mim a=625 p=100
CC0__unit1 net012 net19 sky130_fd_pr__model__cap_mim a=625 p=100
CC0__unit2 net012 net19 sky130_fd_pr__model__cap_mim a=625 p=100
CC0__unit3 net012 net19 sky130_fd_pr__model__cap_mim a=625 p=100
CC0__unit4 net012 net19 sky130_fd_pr__model__cap_mim a=625 p=100
CC0__unit5 net012 net19 sky130_fd_pr__model__cap_mim a=625 p=100
CC0__unit6 net012 net19 sky130_fd_pr__model__cap_mim a=625 p=100
CC0__unit7 net012 net19 sky130_fd_pr__model__cap_mim a=625 p=100
CC0__unit8 net012 net19 sky130_fd_pr__model__cap_mim a=625 p=100
CC0__unit9 net012 net19 sky130_fd_pr__model__cap_mim a=625 p=100
CC0__unit10 net012 net19 sky130_fd_pr__model__cap_mim a=625 p=100
CC0__unit11 net012 net19 sky130_fd_pr__model__cap_mim a=625 p=100
CC0__unit12 net012 net19 sky130_fd_pr__model__cap_mim a=625 p=100
CC0__unit13 net012 net19 sky130_fd_pr__model__cap_mim a=625 p=100
CC0__unit14 net012 net19 sky130_fd_pr__model__cap_mim a=625 p=100
CC0__unit15 net012 net19 sky130_fd_pr__model__cap_mim a=625 p=100
CC0__unit16 net012 net19 sky130_fd_pr__model__cap_mim a=625 p=100
CC0__unit17 net012 net19 sky130_fd_pr__model__cap_mim a=625 p=100
CC0__unit18 net012 net19 sky130_fd_pr__model__cap_mim a=625 p=100
CC0__unit19 net012 net19 sky130_fd_pr__model__cap_mim a=625 p=100
CC0__unit20 net012 net19 sky130_fd_pr__model__cap_mim a=625 p=100
XMNM4 AVDD net018 net012 AVSS sky130_fd_pr__nfet_05v0_nvt w=10 l=0.9 as=2.65 ad=1.4 ps=20.53 pd=10.28 m=2 mult=2
XMNM3 AVDD net012 net018 AVSS sky130_fd_pr__nfet_05v0_nvt w=10 l=0.9 as=2.65 ad=1.4 ps=20.53 pd=10.28 m=2 mult=2
XMNM1 VOUT net018 net018 AVSS sky130_fd_pr__nfet_05v0_nvt w=10 l=0.9 as=2.65 ad=1.4 ps=20.53 pd=10.28 m=2 mult=2
XMNM0 VOUT net012 net012 AVSS sky130_fd_pr__nfet_05v0_nvt w=10 l=0.9 as=2.65 ad=1.4 ps=20.53 pd=10.28 m=2 mult=2
XI1 CLK EN AVDD AVSS net011 ND2D1A
XMPM1 net23 net26 net013 net013 sky130_fd_pr__pfet_01v8 w=1.13 l=0.2 as=0.205283 ad=0.1582 ps=1.87 pd=1.41 m=6 mult=6
XMPM0 net013 ICTR AVDD AVDD sky130_fd_pr__pfet_01v8 w=2 l=0.2 as=0.405 ad=0.28 ps=3.405 pd=2.28 m=8 mult=8
Xmp0 net19 net06 net013 net013 sky130_fd_pr__pfet_01v8 w=1.13 l=0.2 as=0.205283 ad=0.1582 ps=1.87 pd=1.41 m=6 mult=6
.ends charge_pump_regulated_core
