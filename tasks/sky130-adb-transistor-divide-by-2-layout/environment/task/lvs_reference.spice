* Sky130 transistor-level rising-edge divide-by-two flip-flop.
* Asynchronous active-high reset.
*
* Startup and duty symmetry are established by transistor topology and sizing.
* Strengthened clock inverters reduce complementary-clock skew, and the
* buffered Q-to-D inversion prevents transition overlap from racing around the
* feedback loop without relying on an ideal state-storage capacitor.
* The output buffer is sized for balanced rise/fall timing into the 20 fF load.
* Reset is asserted through the slave NOR2; no direct clkout reset clamp is used.
*
.subckt div2_inv a y vdd vss
XMP y a vdd vdd sky130_fd_pr__pfet_01v8 l=0.15 w=2.4 nf=1
XMN y a vss vss sky130_fd_pr__nfet_01v8 l=0.15 w=1.2 nf=1
.ends div2_inv

* ---------------- clock inverter ----------------
* Three times the unit cell and loaded only by transmission-gate control
* inputs, so ckb and cki are separated by one short inverter delay.
.subckt div2_invclk a y vdd vss
XMP y a vdd vdd sky130_fd_pr__pfet_01v8 l=0.15 w=7.2 nf=3
XMN y a vss vss sky130_fd_pr__nfet_01v8 l=0.15 w=3.6 nf=3
.ends div2_invclk

* ---------------- NOR2 with strengthened reset path ----------------
* Series PMOS devices are widened to preserve pull-up strength.
* The data-side NMOS remains at 2.4 um, while the reset-controlled NMOS is
* strengthened independently to meet the asynchronous reset-delay target.
.subckt div2_nor2 a b y vdd vss
XMP0 pmid a vdd vdd sky130_fd_pr__pfet_01v8 l=0.15 w=9.6 nf=4
XMP1 y b pmid vdd sky130_fd_pr__pfet_01v8 l=0.15 w=9.6 nf=4
XMN0 y a vss vss sky130_fd_pr__nfet_01v8 l=0.15 w=2.4 nf=1
XMN1 y b vss vss sky130_fd_pr__nfet_01v8 l=0.15 w=9.6 nf=4
.ends div2_nor2

* ---------------- transmission gate ----------------
.subckt div2_tg a y g gb vdd vss
XMN a g y vss sky130_fd_pr__nfet_01v8 l=0.15 w=2.4 nf=1
XMP a gb y vdd sky130_fd_pr__pfet_01v8 l=0.15 w=4.8 nf=2
.ends div2_tg

* ---------------- output stage ----------------
* Two-stage output buffer sized for balanced edge timing into the 20 fF load.
.subckt div2_buf0 a y vdd vss
XMP y a vdd vdd sky130_fd_pr__pfet_01v8 l=0.15 w=3.6 nf=2
XMN y a vss vss sky130_fd_pr__nfet_01v8 l=0.15 w=1.2 nf=1
.ends div2_buf0

.subckt div2_buf1 a y vdd vss
XMP y a vdd vdd sky130_fd_pr__pfet_01v8 l=0.15 w=9.6 nf=4
XMN y a vss vss sky130_fd_pr__nfet_01v8 l=0.15 w=9.6 nf=8
.ends div2_buf1

* ---------------- master-slave D flip-flop, asynchronous reset ----------------
* Master transparent while clk is low, slave while clk is high. The keeper and
* write gates use opposite phases; the regenerated clocks and buffered Q-to-D
* path give transition overlap time to settle before the next active edge.
.subckt div2_dffr d ckb cki reset q vdd vss
XTGM d mm ckb cki vdd vss div2_tg
XI0 mm mmb vdd vss div2_inv
XI1 mmb mfb vdd vss div2_inv
XTGF mfb mm cki ckb vdd vss div2_tg
XTGS mmb sm cki ckb vdd vss div2_tg
XNQ sm reset q vdd vss div2_nor2
XI2 q sfb vdd vss div2_inv
XTGB sfb sm ckb cki vdd vss div2_tg
.ends div2_dffr

* ---------------- top level ----------------
.subckt divide_by_2 clk reset vdd vss clkout
XCLK0 clk ckb vdd vss div2_invclk
XCLK1 ckb cki vdd vss div2_invclk
XFB1 qstate f1 vdd vss div2_inv
XFB2 f1 f2 vdd vss div2_inv
XFB3 f2 d vdd vss div2_inv
XFF d ckb cki reset qstate vdd vss div2_dffr
XBUF0 qstate qb vdd vss div2_buf0
XBUF1 qb clkout vdd vss div2_buf1
.ends divide_by_2
