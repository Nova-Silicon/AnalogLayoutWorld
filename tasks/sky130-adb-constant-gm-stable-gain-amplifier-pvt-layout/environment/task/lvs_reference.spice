* Sky130 constant-gm gain-stable differential amplifier.
* A beta-multiplier bias loop (K=4 mirror pair degenerated by RB)
* forces the master's transconductance to 1/RB, and the input pair
* runs at the master's exact current density, so the resistor-loaded
* differential gain is RL/RB - a resistor ratio that holds across
* process, supply, and temperature where any fixed-current bias would
* swing with mobility. The bench's iref current parks in a diode and
* trickles a startup pull into the loop's PMOS diode so the
* self-biased loop can never latch off.
.subckt cgm_amp vss iref vdd vinp vinn voutp voutn
* -- iref termination and startup trickle --
XMIRT iref iref vss vss sky130_fd_pr__nfet_01v8 l=1 w=20 nf=5
XMSTU nc iref vss vss sky130_fd_pr__nfet_01v8 l=8 w=0.42 nf=1
* -- beta-multiplier constant-gm loop --
XMB1 nb nb vss vss sky130_fd_pr__nfet_01v8 l=1 w=16 nf=4
XMB2 nc nb rb2 vss sky130_fd_pr__nfet_01v8 l=1 w=64 nf=16
XRB rb2 vss vss sky130_fd_pr__res_high_po_1p41 l=7.51 m=1
XMBP1 nb nc vdd vdd sky130_fd_pr__pfet_01v8 l=1 w=32 nf=8
XMBP2 nc nc vdd vdd sky130_fd_pr__pfet_01v8 l=1 w=32 nf=8
* -- resistor-loaded differential pair at the master's density --
XMT tl nb vss vss sky130_fd_pr__nfet_01v8 l=1 w=32 nf=8
XMA1 voutn vinp tl vss sky130_fd_pr__nfet_01v8 l=1 w=16 nf=4
XMA2 voutp vinn tl vss sky130_fd_pr__nfet_01v8 l=1 w=16 nf=4
XRL1 vdd voutn vss sky130_fd_pr__res_high_po_1p41 l=33.65 m=1
XRL2 vdd voutp vss sky130_fd_pr__res_high_po_1p41 l=33.65 m=1
.ends cgm_amp
