* programmable_current_mirror -- reference solution (full design history,
* rejected alternatives, and measured margins are recorded in Git history).
* Topology:
*  - icc_ref / iptat_ref: diode-connected NMOS references, L=0.5 (SAME
*    channel length as the output legs -- an earlier draft mismatched
*    diode L=0.15 vs leg L=0.5 to cancel DC error at tt/27C, but the two
*    lengths carry different short-channel/velocity-saturation shape and
*    the "cancellation" blew up to +51%/-38% error at the ss/-40C and
*    ff/125C signoff corners. Same-L keeps the systematic Vds-mismatch
*    error small AND consistent in sign/magnitude across corners.
*  - output legs: same L=0.5, W=8*weight (weight in {4,8,12,16}), gate
*    tied directly to icc_ref/iptat_ref, drain into a per-code presum
*    node, source at vss. Operating at Vds~0.45-0.55V (below the diode's
*    own ~0.7-0.85V Vds) gives a systematic current shortfall from
*    channel-length modulation -- verified by direct simulation to stay
*    within roughly -2% to -9% (output current) / -4% to -9% (weight
*    slope) across all three signoff corners, comfortably inside the
*    8%/10% bars (see Git history for the exact measured numbers).
*  - static CMOS decode (2 inverters) + one-hot select via series NMOS
*    switch pairs (AND-by-stacking) per code, landing on a common isum
*    node.
*  - single shared output cascode (isum -> iout), gate biased by a
*    resistor + 2 stacked diodes off vdd (code-independent). The bias
*    generator's own devices are deliberately L-matched to the leg
*    (L=0.5) and cascode (L=0.35) devices they bias -- an earlier
*    version used L=0.15 bias devices and the resulting Vcasc tracked
*    poorly across corners, letting isum collapse toward the legs' own
*    Vdsat at ff/125C and blowing the weight-accuracy bar there.
.subckt programmable_current_mirror vss vdd icc_ref iptat_ref ratio_b0 ratio_b1 iout

* --- reference diodes (carry only the externally forced current) ---
XMD_ICC   icc_ref   icc_ref   vss vss sky130_fd_pr__nfet_01v8 l=0.5 w=8 nf=1
XMD_IPTAT iptat_ref iptat_ref vss vss sky130_fd_pr__nfet_01v8 l=0.5 w=8 nf=1

* --- static CMOS inverters for decode (b0,b1 -> nb0,nb1) ---
XMPINVB0 nb0 ratio_b0 vdd vdd sky130_fd_pr__pfet_01v8 l=0.15 w=1 nf=1
XMNINVB0 nb0 ratio_b0 vss vss sky130_fd_pr__nfet_01v8 l=0.15 w=0.5 nf=1
XMPINVB1 nb1 ratio_b1 vdd vdd sky130_fd_pr__pfet_01v8 l=0.15 w=1 nf=1
XMNINVB1 nb1 ratio_b1 vss vss sky130_fd_pr__nfet_01v8 l=0.15 w=0.5 nf=1

* --- output legs: gate tied directly to icc_ref / iptat_ref, L=0.5,
*     W=8*weight, drain into a per-code presum node, source at vss. ---
XMLEG_ICC00   presum00 icc_ref   vss vss sky130_fd_pr__nfet_01v8 l=0.5 w=128 nf=2
XMLEG_IPTAT00 presum00 iptat_ref vss vss sky130_fd_pr__nfet_01v8 l=0.5 w=32  nf=1

XMLEG_ICC01   presum01 icc_ref   vss vss sky130_fd_pr__nfet_01v8 l=0.5 w=96  nf=1
XMLEG_IPTAT01 presum01 iptat_ref vss vss sky130_fd_pr__nfet_01v8 l=0.5 w=64  nf=1

XMLEG_ICC10   presum10 icc_ref   vss vss sky130_fd_pr__nfet_01v8 l=0.5 w=64  nf=1
XMLEG_IPTAT10 presum10 iptat_ref vss vss sky130_fd_pr__nfet_01v8 l=0.5 w=96  nf=1

XMLEG_ICC11   presum11 icc_ref   vss vss sky130_fd_pr__nfet_01v8 l=0.5 w=32  nf=1
XMLEG_IPTAT11 presum11 iptat_ref vss vss sky130_fd_pr__nfet_01v8 l=0.5 w=128 nf=2

* --- one-hot select switches: series NMOS pair (AND by stacking) per code,
*     gates driven by true/complement of ratio_b1/ratio_b0. ---
* code 00: b1=0,b0=0 -> gate with nb1, nb0
XMSW00A presum00 nb1 mid00 vss sky130_fd_pr__nfet_01v8 l=0.15 w=80 nf=8
XMSW00B mid00    nb0 isum  vss sky130_fd_pr__nfet_01v8 l=0.15 w=80 nf=8
* code 01: b1=0,b0=1 -> gate with nb1, ratio_b0
XMSW01A presum01 nb1 mid01 vss sky130_fd_pr__nfet_01v8 l=0.15 w=80 nf=8
XMSW01B mid01    ratio_b0 isum vss sky130_fd_pr__nfet_01v8 l=0.15 w=80 nf=8
* code 10: b1=1,b0=0 -> gate with ratio_b1, nb0
XMSW10A presum10 ratio_b1 mid10 vss sky130_fd_pr__nfet_01v8 l=0.15 w=80 nf=8
XMSW10B mid10    nb0 isum vss sky130_fd_pr__nfet_01v8 l=0.15 w=80 nf=8
* code 11: b1=1,b0=1 -> gate with ratio_b1, ratio_b0
XMSW11A presum11 ratio_b1 mid11 vss sky130_fd_pr__nfet_01v8 l=0.15 w=80 nf=8
XMSW11B mid11    ratio_b0 isum vss sky130_fd_pr__nfet_01v8 l=0.15 w=80 nf=8

* --- cascode bias generator: R + 2 stacked diodes off vdd. Small W / small
*     R keeps the stack in strong inversion so Vcasc lands high enough to
*     overcome the output cascode's own body effect (bulk=vss, source
*     sits at isum > 0V). ---
XRCASC vdd ncb1 sky130_fd_pr__res_generic_po w=1.00 l=3917.01 m=1
XMCB1 ncb1 ncb1 ncb2 vss sky130_fd_pr__nfet_01v8 l=0.35 w=8 nf=1
XMCB2 ncb2 ncb2 vss  vss sky130_fd_pr__nfet_01v8 l=0.5  w=8 nf=1

* --- output cascode: large W for low Vdsat (headroom) and high gm (Rout) ---
XMCASC iout ncb1 isum vss sky130_fd_pr__nfet_01v8 l=0.35 w=400 nf=20

.ends programmable_current_mirror
