* Sky130 900 MS/s fully differential floating-capacitor-transfer residue amplifier.
* TEST_FCT DUT restored from the supplied Cadence Spectre hierarchy.
* MOS terminal order: D G S B (drain gate source bulk/body)
* Reference devices keep each modeled finger at or below about 18.4 um.
* Junction geometry models unshared 0.14 um source/drain diffusions using
* total W: A=0.14*W, P=2*W+0.28*nf.

* Transistor-level clock buffer used inside TEST_FCT.
.subckt fct_clock_buffer A Y inh_VDD inh_VSS
XN_OUTPUT inh_VSS buffer_mid Y inh_VSS sky130_fd_pr__nfet_01v8 l=0.15 w=12.16 nf=1 as=1.7024 ad=1.7024 ps=24.6 pd=24.6
XN_INPUT inh_VSS A buffer_mid inh_VSS sky130_fd_pr__nfet_01v8 l=0.15 w=3.04 nf=1 as=0.4256 ad=0.4256 ps=6.36 pd=6.36
XP_OUTPUT Y buffer_mid inh_VDD inh_VDD sky130_fd_pr__pfet_01v8 l=0.15 w=18.08 nf=1 as=2.5312 ad=2.5312 ps=36.44 pd=36.44
XP_INPUT buffer_mid A inh_VDD inh_VDD sky130_fd_pr__pfet_01v8 l=0.15 w=4.52 nf=1 as=0.6328 ad=0.6328 ps=9.32 pd=9.32
.ends fct_clock_buffer

* fct clock inverter
.subckt fct_clock_inverter A Y inh_VDD inh_VSS
XP_INVERTER Y A inh_VDD inh_VDD sky130_fd_pr__pfet_01v8 l=0.15 w=18.08 nf=1 as=2.5312 ad=2.5312 ps=36.44 pd=36.44
XN_INVERTER Y A inh_VSS inh_VSS sky130_fd_pr__nfet_01v8 l=0.15 w=12.16 nf=1 as=1.7024 ad=1.7024 ps=24.6 pd=24.6
.ends fct_clock_inverter

* Original TEST_FCT boundary. Sampling, flying capacitors, output precharge,
* and output track-and-hold fixtures are supplied by the testbench.
.subckt test_fct cinn cinp coutn coutp ib sam transfer vcm vddana vdddig vssana vssdig
XP_OUTPUT_01 coutn output_en_b outn_pullup_node reservoir_hi_n sky130_fd_pr__pfet_01v8 l=0.15 w=3.6 nf=1 as=0.504 ad=0.504 ps=7.48 pd=7.48
XP_INPUT_01 bias_input_reset reset_b_main input_ctrl_p_a vdddig sky130_fd_pr__pfet_01v8 l=0.15 w=6 nf=1 as=0.84 ad=0.84 ps=12.28 pd=12.28
XP_INPUT_02 bias_input_reset reset_b_main input_ctrl_p_b vdddig sky130_fd_pr__pfet_01v8 l=0.15 w=6 nf=1 as=0.84 ad=0.84 ps=12.28 pd=12.28
XP_INPUT_03 vcm reset_b_main cinn vdddig sky130_fd_pr__pfet_01v8 l=0.15 w=12 nf=1 as=1.68 ad=1.68 ps=24.28 pd=24.28
XP_RESERVOIR_01 bias_n_cascode reset_b_bias reservoir_gate_lo_n vddana sky130_fd_pr__pfet_01v8 l=0.15 w=2.4 nf=1 as=0.336 ad=0.336 ps=5.08 pd=5.08
XP_INPUT_04 vcm reset_b_main cinp vdddig sky130_fd_pr__pfet_01v8 l=0.15 w=12 nf=1 as=1.68 ad=1.68 ps=24.28 pd=24.28
XP_INPUT_05 bias_reservoir_reset reset_b_main input_ctrl_n_a vdddig sky130_fd_pr__pfet_01v8 l=0.15 w=6 nf=1 as=0.84 ad=0.84 ps=12.28 pd=12.28
XP_RESERVOIR_02 bias_n_cascode reset_b_bias reservoir_gate_lo_p vddana sky130_fd_pr__pfet_01v8 l=0.15 w=2.4 nf=1 as=0.336 ad=0.336 ps=5.08 pd=5.08
XP_RESERVOIR_03 bias_p_cascode reset_b_bias reservoir_gate_hi_p vddana sky130_fd_pr__pfet_01v8 l=0.15 w=2.4 nf=1 as=0.336 ad=0.336 ps=5.08 pd=5.08
XP_RESERVOIR_04 bias_p_cascode reset_b_bias reservoir_gate_hi_n vddana sky130_fd_pr__pfet_01v8 l=0.15 w=2.4 nf=1 as=0.336 ad=0.336 ps=5.08 pd=5.08
XP_INPUT_06 bias_reservoir_reset reset_b_main input_ctrl_n_b vdddig sky130_fd_pr__pfet_01v8 l=0.15 w=6 nf=1 as=0.84 ad=0.84 ps=12.28 pd=12.28
XP_INPUT_07 input_branch_p input_ctrl_n_a cinp cinp sky130_fd_pr__pfet_01v8 l=0.15 w=8.0625 nf=1 m=10 as=1.12875 ad=1.12875 ps=16.405 pd=16.405
XP_INPUT_08 input_branch_n input_ctrl_n_b cinn cinn sky130_fd_pr__pfet_01v8 l=0.15 w=8.0625 nf=1 m=10 as=1.12875 ad=1.12875 ps=16.405 pd=16.405
* SFDR/common-mode sizing: balanced output pull devices and NMOS bias mirror.
XP_OUTPUT_02 outp_pullup_node reservoir_gate_hi_n reservoir_hi_p reservoir_hi_p sky130_fd_pr__pfet_01v8 l=0.15 w=33 nf=2 as=4.62 ad=4.62 ps=66.56 pd=66.56
XP_OUTPUT_03 outn_pullup_node reservoir_gate_hi_p reservoir_hi_n reservoir_hi_n sky130_fd_pr__pfet_01v8 l=0.15 w=33 nf=2 as=4.62 ad=4.62 ps=66.56 pd=66.56
XP_RESERVOIR_05 reservoir_hi_p reset_b_res_p vddana vdddig sky130_fd_pr__pfet_01v8 l=0.15 w=36 nf=2 as=5.04 ad=5.04 ps=72.56 pd=72.56
XP_RESERVOIR_06 reservoir_hi_n reset_b_res_n vddana vdddig sky130_fd_pr__pfet_01v8 l=0.15 w=36 nf=2 as=5.04 ad=5.04 ps=72.56 pd=72.56
XP_RESERVOIR_07 transfer_branch_p transfer_en_b reservoir_hi_p reservoir_hi_p sky130_fd_pr__pfet_01v8 l=0.15 w=11 nf=1 as=1.54 ad=1.54 ps=22.28 pd=22.28
XP_RESERVOIR_08 transfer_branch_n transfer_en_b reservoir_hi_n reservoir_hi_n sky130_fd_pr__pfet_01v8 l=0.15 w=11 nf=1 as=1.54 ad=1.54 ps=22.28 pd=22.28
XP_INPUT_09 bias_input_reset bias_p_gate vddana vddana sky130_fd_pr__pfet_01v8 l=0.15 w=11 nf=1 as=1.54 ad=1.54 ps=22.28 pd=22.28
XP_INPUT_10 bias_n_diode bias_n_diode vcm vcm sky130_fd_pr__pfet_01v8 l=0.15 w=8.0625 nf=1 as=1.12875 ad=1.12875 ps=16.405 pd=16.405
XP_BIAS_01 bias_p_branch_1 bias_p_gate vddana vddana sky130_fd_pr__pfet_01v8 l=0.15 w=11 nf=1 as=1.54 ad=1.54 ps=22.28 pd=22.28
XP_BIAS_02 bias_p_branch_2 bias_p_gate vddana vddana sky130_fd_pr__pfet_01v8 l=0.15 w=11 nf=1 as=1.54 ad=1.54 ps=22.28 pd=22.28
XP_BIAS_03 bias_p_branch_3 bias_p_gate vddana vddana sky130_fd_pr__pfet_01v8 l=0.15 w=11 nf=1 as=1.54 ad=1.54 ps=22.28 pd=22.28
XP_BIAS_04 bias_p_branch_4 bias_p_gate vddana vddana sky130_fd_pr__pfet_01v8 l=0.15 w=11 nf=1 as=1.54 ad=1.54 ps=22.28 pd=22.28
XP_BIAS_05 bias_p_branch_4 bias_p_gate vddana vddana sky130_fd_pr__pfet_01v8 l=0.15 w=11 nf=1 as=1.54 ad=1.54 ps=22.28 pd=22.28
XP_BIAS_06 bias_mid_n bias_mid_p bias_p_branch_3 vddana sky130_fd_pr__pfet_01v8 l=0.15 w=11 nf=1 as=1.54 ad=1.54 ps=22.28 pd=22.28
XP_BIAS_07 bias_n_cascode bias_mid_p bias_p_branch_1 vddana sky130_fd_pr__pfet_01v8 l=0.15 w=11 nf=1 as=1.54 ad=1.54 ps=22.28 pd=22.28
XP_BIAS_08 bias_p_gate bias_mid_p bias_p_branch_2 vddana sky130_fd_pr__pfet_01v8 l=0.15 w=11 nf=1 as=1.54 ad=1.54 ps=22.28 pd=22.28
XP_BIAS_09 bias_mid_p bias_mid_p bias_p_branch_4 vddana sky130_fd_pr__pfet_01v8 l=0.15 w=11 nf=1 as=1.54 ad=1.54 ps=22.28 pd=22.28
XP_INPUT_11 bias_reservoir_reset bias_reservoir_reset vcm vcm sky130_fd_pr__pfet_01v8 l=0.15 w=8.0625 nf=1 as=1.12875 ad=1.12875 ps=16.405 pd=16.405
XP_OUTPUT_04 coutp output_en_b outp_pullup_node reservoir_hi_p sky130_fd_pr__pfet_01v8 l=0.15 w=3.6 nf=1 as=0.504 ad=0.504 ps=7.48 pd=7.48
XP_BIAS_10 bias_p_cascode bias_p_cascode vddana vddana sky130_fd_pr__pfet_01v8 l=0.15 w=11 nf=1 as=1.54 ad=1.54 ps=22.28 pd=22.28
XC_INPUT_01 cinp input_ctrl_p_a sky130_fd_pr__cap_mim_m3_1 w=22.210 l=22.210
XC_BIAS_01 vddana bias_p_cascode sky130_fd_pr__cap_mim_m3_1 w=14.970 l=14.970
XC_RESERVOIR_01 reservoir_hi_p reservoir_lo_p sky130_fd_pr__cap_mim_m3_1 w=31.475 l=31.475
XC_RESERVOIR_02 reservoir_gate_lo_p reservoir_lo_n sky130_fd_pr__cap_mim_m3_1 w=13.375 l=13.375
XC_BIAS_02 vssana bias_n_cascode sky130_fd_pr__cap_mim_m3_1 w=14.970 l=14.970
XC_INPUT_02 cinn input_ctrl_n_a sky130_fd_pr__cap_mim_m3_1 w=22.210 l=22.210
XC_INPUT_03 cinn input_ctrl_p_b sky130_fd_pr__cap_mim_m3_1 w=22.210 l=22.210
XC_RESERVOIR_03 reservoir_hi_n reservoir_lo_n sky130_fd_pr__cap_mim_m3_1 w=31.475 l=31.475
XC_RESERVOIR_04 reservoir_gate_hi_n reservoir_hi_n sky130_fd_pr__cap_mim_m3_1 w=13.375 l=13.375
XC_RESERVOIR_05 reservoir_gate_hi_p reservoir_hi_p sky130_fd_pr__cap_mim_m3_1 w=13.375 l=13.375
XC_RESERVOIR_06 reservoir_gate_lo_n reservoir_lo_p sky130_fd_pr__cap_mim_m3_1 w=13.375 l=13.375
XC_INPUT_04 cinp input_ctrl_n_b sky130_fd_pr__cap_mim_m3_1 w=22.210 l=22.210
XC_INPUT_05 vcm bias_reservoir_reset sky130_fd_pr__cap_mim_m3_1 w=14.535 l=14.535
XC_INPUT_06 vcm bias_input_reset sky130_fd_pr__cap_mim_m3_1 w=14.535 l=14.535
X_CLOCK_01 sam reset_n_res_n vdddig vssdig fct_clock_buffer
X_CLOCK_02 transfer output_en_n vdddig vssdig fct_clock_buffer
X_CLOCK_03 sam reset_n_bias vdddig vssdig fct_clock_buffer
X_CLOCK_04 sam reset_n_res_p vdddig vssdig fct_clock_buffer
X_CLOCK_05 transfer transfer_en_n vdddig vssdig fct_clock_buffer
X_CLOCK_06 sam reset_n_main vdddig vssdig fct_clock_buffer
XN_OUTPUT_01 coutn output_en_n outn_pulldown_node reservoir_lo_n sky130_fd_pr__nfet_01v8 l=0.15 w=1.26 nf=1 as=0.1764 ad=0.1764 ps=2.8 pd=2.8
XN_RESERVOIR_01 reservoir_gate_lo_p reset_n_bias bias_n_cascode vssana sky130_fd_pr__nfet_01v8 l=0.15 w=2.4 nf=1 as=0.336 ad=0.336 ps=5.08 pd=5.08
XN_RESERVOIR_02 reservoir_gate_hi_p reset_n_bias bias_p_cascode vssana sky130_fd_pr__nfet_01v8 l=0.15 w=2.4 nf=1 as=0.336 ad=0.336 ps=5.08 pd=5.08
XN_INPUT_01 input_ctrl_n_b reset_n_main bias_reservoir_reset vssana sky130_fd_pr__nfet_01v8 l=0.15 w=6 nf=1 as=0.84 ad=0.84 ps=12.28 pd=12.28
XN_OUTPUT_02 coutp output_en_n outp_pulldown_node reservoir_lo_p sky130_fd_pr__nfet_01v8 l=0.15 w=1.26 nf=1 as=0.1764 ad=0.1764 ps=2.8 pd=2.8
XN_INPUT_02 input_ctrl_p_b reset_n_main bias_input_reset vssana sky130_fd_pr__nfet_01v8 l=0.15 w=6 nf=1 as=0.84 ad=0.84 ps=12.28 pd=12.28
XN_INPUT_03 cinn reset_n_main vcm vssana sky130_fd_pr__nfet_01v8 l=0.15 w=12 nf=1 as=1.68 ad=1.68 ps=24.28 pd=24.28
XN_RESERVOIR_03 reservoir_gate_lo_n reset_n_bias bias_n_cascode vssana sky130_fd_pr__nfet_01v8 l=0.15 w=2.4 nf=1 as=0.336 ad=0.336 ps=5.08 pd=5.08
XN_INPUT_04 input_ctrl_n_a reset_n_main bias_reservoir_reset vssana sky130_fd_pr__nfet_01v8 l=0.15 w=6 nf=1 as=0.84 ad=0.84 ps=12.28 pd=12.28
XN_INPUT_05 cinp reset_n_main vcm vssana sky130_fd_pr__nfet_01v8 l=0.15 w=12 nf=1 as=1.68 ad=1.68 ps=24.28 pd=24.28
XN_INPUT_06 bias_p_branch_4 bias_p_branch_4 vcm vcm sky130_fd_pr__nfet_01v8 l=0.15 w=3.3 nf=1 as=0.462 ad=0.462 ps=6.88 pd=6.88
XN_BIAS_01 ib bias_mid_n bias_n_branch_4 vssana sky130_fd_pr__nfet_01v8 l=0.15 w=7.2 nf=1 as=1.008 ad=1.008 ps=14.68 pd=14.68
XN_INPUT_07 transfer_branch_n input_ctrl_p_b cinp cinp sky130_fd_pr__nfet_01v8 l=0.15 w=3.3 nf=1 m=10 as=0.462 ad=0.462 ps=6.88 pd=6.88
XN_INPUT_08 transfer_branch_p input_ctrl_p_a cinn cinn sky130_fd_pr__nfet_01v8 l=0.15 w=3.3 nf=1 m=10 as=0.462 ad=0.462 ps=6.88 pd=6.88
XN_OUTPUT_03 outp_pulldown_node reservoir_gate_lo_p reservoir_lo_p reservoir_lo_p sky130_fd_pr__nfet_01v8 l=0.15 w=6.3 nf=1 as=0.882 ad=0.882 ps=12.88 pd=12.88
XN_OUTPUT_04 outn_pulldown_node reservoir_gate_lo_n reservoir_lo_n reservoir_lo_n sky130_fd_pr__nfet_01v8 l=0.15 w=6.3 nf=1 as=0.882 ad=0.882 ps=12.88 pd=12.88
XN_RESERVOIR_04 reservoir_lo_p reset_n_res_p vssana vssdig sky130_fd_pr__nfet_01v8 l=0.15 w=36 nf=2 as=5.04 ad=5.04 ps=72.56 pd=72.56
XN_RESERVOIR_05 reservoir_lo_n reset_n_res_n vssana vssdig sky130_fd_pr__nfet_01v8 l=0.15 w=36 nf=2 as=5.04 ad=5.04 ps=72.56 pd=72.56
XN_INPUT_09 input_branch_n transfer_en_n reservoir_lo_p vssana sky130_fd_pr__nfet_01v8 l=0.15 w=11 nf=1 as=1.54 ad=1.54 ps=22.28 pd=22.28
XN_INPUT_10 input_branch_p transfer_en_n reservoir_lo_n vssana sky130_fd_pr__nfet_01v8 l=0.15 w=11 nf=1 as=1.54 ad=1.54 ps=22.28 pd=22.28
XN_INPUT_11 input_ctrl_p_a reset_n_main bias_input_reset vssana sky130_fd_pr__nfet_01v8 l=0.15 w=6 nf=1 as=0.84 ad=0.84 ps=12.28 pd=12.28
XN_INPUT_12 bias_input_reset bias_input_reset vcm vcm sky130_fd_pr__nfet_01v8 l=0.15 w=3.3 nf=1 as=0.462 ad=0.462 ps=6.88 pd=6.88
XN_BIAS_02 bias_n_branch_1 ib vssana vssana sky130_fd_pr__nfet_01v8 l=0.15 w=7.2 nf=1 as=1.008 ad=1.008 ps=14.68 pd=14.68
XN_BIAS_03 bias_p_gate bias_mid_n bias_n_branch_1 vssana sky130_fd_pr__nfet_01v8 l=0.15 w=7.2 nf=1 as=1.008 ad=1.008 ps=14.68 pd=14.68
XN_BIAS_04 bias_p_cascode bias_mid_n bias_n_branch_2 vssana sky130_fd_pr__nfet_01v8 l=0.15 w=7.2 nf=1 as=1.008 ad=1.008 ps=14.68 pd=14.68
XN_BIAS_05 bias_n_diode ib vssana vssana sky130_fd_pr__nfet_01v8 l=0.15 w=7.2 nf=1 as=1.008 ad=1.008 ps=14.68 pd=14.68
XN_BIAS_06 bias_mid_n bias_mid_n bias_n_diode vssana sky130_fd_pr__nfet_01v8 l=0.15 w=7.2 nf=1 as=1.008 ad=1.008 ps=14.68 pd=14.68
XN_BIAS_07 bias_n_branch_4 ib vssana vssana sky130_fd_pr__nfet_01v8 l=0.15 w=7.2 nf=1 as=1.008 ad=1.008 ps=14.68 pd=14.68
XN_BIAS_08 bias_mid_p bias_mid_n bias_n_branch_3 vssana sky130_fd_pr__nfet_01v8 l=0.15 w=7.2 nf=1 as=1.008 ad=1.008 ps=14.68 pd=14.68
XN_BIAS_09 bias_n_branch_3 ib vssana vssana sky130_fd_pr__nfet_01v8 l=0.15 w=7.2 nf=1 as=1.008 ad=1.008 ps=14.68 pd=14.68
XN_BIAS_10 bias_n_diode ib vssana vssana sky130_fd_pr__nfet_01v8 l=0.15 w=7.2 nf=1 as=1.008 ad=1.008 ps=14.68 pd=14.68
XN_BIAS_11 bias_n_branch_2 ib vssana vssana sky130_fd_pr__nfet_01v8 l=0.15 w=7.2 nf=1 as=1.008 ad=1.008 ps=14.68 pd=14.68
XN_BIAS_12 bias_n_cascode bias_n_cascode vssana vssana sky130_fd_pr__nfet_01v8 l=0.15 w=7.2 nf=1 as=1.008 ad=1.008 ps=14.68 pd=14.68
XN_RESERVOIR_06 bias_reservoir_reset ib vssana vssana sky130_fd_pr__nfet_01v8 l=0.15 w=4.5 nf=1 as=0.63 ad=0.63 ps=9.28 pd=9.28
XN_RESERVOIR_07 reservoir_gate_hi_n reset_n_bias bias_p_cascode vssana sky130_fd_pr__nfet_01v8 l=0.15 w=2.4 nf=1 as=0.336 ad=0.336 ps=5.08 pd=5.08
X_CLOCK_07 sam reset_b_res_n vdddig vssdig fct_clock_inverter
X_CLOCK_08 transfer output_en_b vdddig vssdig fct_clock_inverter
X_CLOCK_09 sam reset_b_bias vdddig vssdig fct_clock_inverter
X_CLOCK_10 transfer transfer_en_b vdddig vssdig fct_clock_inverter
X_CLOCK_11 sam reset_b_res_p vdddig vssdig fct_clock_inverter
X_CLOCK_12 sam reset_b_main vdddig vssdig fct_clock_inverter
.ends test_fct
