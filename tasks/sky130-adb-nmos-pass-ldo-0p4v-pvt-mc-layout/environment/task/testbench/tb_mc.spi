* One hidden deterministic local-mismatch sample at both load endpoints.
.option seed=12345
.lib "/opt/analog-layout/pdks/sky130/sky130A/libs.tech/combined/continuous/sky130.lib.spice" tt_mm
.include "dut.spice"
.options reltol=2e-4 abstol=1e-12 vntol=1e-7 method=gear
.temp 27

VDD vdd 0 1.8
VREF vref 0 0.4
IBIAS ibias 0 40u
CLOAD vout 0 10p
VLOOP loop_out pass_gate 0
XDUT vdd vout 0 vref ibias loop_out pass_gate nmos_pass_ldo
* Load: ILOAD is the ideal reference current (the commanded load) of a
* test-bench 1:1 NMOS low-voltage cascode current mirror.  The reference device
* is diode-connected through its cascode; ETBLD/VTBLD hold both cascode gates
* 0.2 V above the reference gate, so both bottom devices see the same VDS and
* the output stays saturated at vout = 0.4 V.  The output stack draws the load
* from vout through the 0 V meter VLMEAS.  The mirror transistors (XTBLD_*)
* are test-bench devices and are excluded from the DUT headroom check.
* (placed after the DUT so the DUT devices draw the same mismatch samples
* per seed as before the test-bench mirror was added)
ILOAD 0 tbld_ref 1m
XTBLD_REFC tbld_ref tbld_c tbld_s 0 sky130_fd_pr__nfet_01v8_lvt l=0.5 w=50 nf=1 m=80 mult=80
XTBLD_REF tbld_s tbld_ref 0 0 sky130_fd_pr__nfet_01v8_lvt l=0.5 w=50 nf=1 m=80 mult=80
ETBLD tbld_cx 0 tbld_ref 0 1
VTBLD tbld_c tbld_cx 0.2
VLMEAS vout tbld_d 0
XTBLD_OUTC tbld_d tbld_c tbld_m 0 sky130_fd_pr__nfet_01v8_lvt l=0.5 w=50 nf=1 m=80 mult=80
XTBLD_OUT tbld_m tbld_ref 0 0 sky130_fd_pr__nfet_01v8_lvt l=0.5 w=50 nf=1 m=80 mult=80

.control
set noaskquit
* Operating points from a transient power-up (ngspice 46 optran): skip the
* Newton, gmin-stepping and source-stepping DC attempts and integrate from
* all-zero node voltages with every source at its t=0 value; the final state
* is the operating point.  Gear integration (method=gear in .options) keeps the
* DC branch currents read from that state free of trapezoidal ringing.
optran 0 0 0 1u 1m 0
op
let mc_vout_1ma_v = v(vout)
print mc_vout_1ma_v
alter ILOAD 5m
op
let mc_vout_5ma_v = v(vout)
print mc_vout_5ma_v
quit
.endc
.end
