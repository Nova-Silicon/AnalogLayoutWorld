* Sky130 PLL charge pump: current-steering, cascoded UP/DN branches,
* replica-matched bias network derived only from iref (25 uA in).
* XN d g s b sky130_fd_pr__nfet_01v8 l=0.5 w=8 nf=2
* XP d g s b sky130_fd_pr__pfet_01v8 l=0.5 w=16 nf=4
.subckt pll_charge_pump vss iref up dn vdd vout
*
* ---------- reference input: diode NMOS on iref (mirror master) ----------
XMN0 iref iref vss vss sky130_fd_pr__nfet_01v8 l=6 w=84 nf=4
*
* ---------- B2: PMOS cascode bias vbpc (Pcb diode fed by N-mirror) ----------
XMPCB vbpc vbpc vdd vdd sky130_fd_pr__pfet_01v8 l=3 w=27 nf=1
XMN2 vbpc iref vss vss sky130_fd_pr__nfet_01v8 l=6 w=42 nf=2
*
* ---------- B3: NMOS cascode bias vbnc (Ncb diode fed from vbpc source) ----------
XMP2X vbnc vbpc vdd vdd sky130_fd_pr__pfet_01v8 l=3 w=24 nf=1
XMNCB vbnc vbnc vss vss sky130_fd_pr__nfet_01v8 l=6 w=3.9 nf=1
*
* ---------- B1: replica branch -> vbp (cascoded diode, matches main UP stack) ----------
XMP0 n1a vbp vdd vdd sky130_fd_pr__pfet_01v8 l=3 w=150 nf=5
XMPC0 vbp vbpc n1a vdd sky130_fd_pr__pfet_01v8 l=0.9 w=90 nf=3
XMNC1 vbp vbnc n1b vss sky130_fd_pr__nfet_01v8 l=1.5 w=30 nf=2
XMN1 n1b iref vss vss sky130_fd_pr__nfet_01v8 l=6 w=43.98 nf=2
*
* ---------- UP branch: PMOS mirror + cascode + steering pair ----------
XMPM na vbp vdd vdd sky130_fd_pr__pfet_01v8 l=3 w=600 nf=20
XMPC nc vbpc na vdd sky130_fd_pr__pfet_01v8 l=0.9 w=360 nf=12
XMSUP vout upb nc vdd sky130_fd_pr__pfet_01v8 l=0.15 w=24 nf=3
XMSDU wu upd nc vdd sky130_fd_pr__pfet_01v8 l=0.15 w=24 nf=3
XMNWU wu wu vss vss sky130_fd_pr__nfet_01v8 l=0.5 w=3.5 nf=1
*
* ---------- DN branch: NMOS mirror + cascode + steering pair ----------
XMNM ne iref vss vss sky130_fd_pr__nfet_01v8 l=6 w=175.92 nf=8
XMNC nd vbnc ne vss sky130_fd_pr__nfet_01v8 l=1.5 w=120 nf=8
XMSDN vout dn nd vss sky130_fd_pr__nfet_01v8 l=0.15 w=8 nf=1
XMSDD wd dnb nd vss sky130_fd_pr__nfet_01v8 l=0.15 w=8 nf=1
XMNWD vdd vdd wd vss sky130_fd_pr__nfet_01v8 l=0.5 w=4.5 nf=1
*
* ---------- input inverters/buffers (up/dn drive gates only) ----------
XMIP1 upb up vdd vdd sky130_fd_pr__pfet_01v8 l=0.15 w=24 nf=3
XMIN1 upb up vss vss sky130_fd_pr__nfet_01v8 l=0.15 w=4 nf=1
XMIP2 upd upb vdd vdd sky130_fd_pr__pfet_01v8 l=0.15 w=8 nf=1
XMIN2 upd upb vss vss sky130_fd_pr__nfet_01v8 l=0.15 w=2 nf=1
XMIP3 dnb dn vdd vdd sky130_fd_pr__pfet_01v8 l=0.15 w=24 nf=3
XMIN3 dnb dn vss vss sky130_fd_pr__nfet_01v8 l=0.15 w=0.6 nf=1
*
* ---------- bias filtering / node stiffening (no DC paths) ----------
CCBP vbp vdd sky130_fd_pr__model__cap_mim a=492.84 p=88.8
CCBPC vbpc vdd sky130_fd_pr__model__cap_mim a=492.84 p=88.8
CCBNC vbnc vss sky130_fd_pr__model__cap_mim a=492.84 p=88.8
CCIR iref vss sky130_fd_pr__model__cap_mim a=393.6256 p=79.36
CCWU wu vss sky130_fd_pr__model__cap_mim a=195.4404 p=55.92
CCWD wd vdd sky130_fd_pr__model__cap_mim a=195.4404 p=55.92
CCNC nc vss sky130_fd_pr__model__cap_mim a=18.5761 p=17.24
CCND nd vss sky130_fd_pr__model__cap_mim a=13.7641 p=14.84
.ends pll_charge_pump
