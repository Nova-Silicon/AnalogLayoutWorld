* Sky130 fully differential two-stage Miller op amp with a folded-cascode first stage.
* The implementation uses symmetric common-source output stages, series-RC
* Miller compensation, and continuous-time transistor-level CMFB.
.subckt fd_two_stage_miller_opamp vss iref vdd vinn vinp vocm voutn voutp
* -- single-reference, all-MOS bias generation --
XMREF iref iref vss vss sky130_fd_pr__nfet_01v8 l=1 w=16 nf=4
XMNBP vbp iref vss vss sky130_fd_pr__nfet_01v8 l=1 w=16 nf=4
XMPBP vbp vbp vdd vdd sky130_fd_pr__pfet_01v8 l=1 w=32 nf=8

* PMOS folding-cascode replica.  The 25 uA branch copies both the current
* density of the 100 uA top source (16/64 width scaling) and the 25 uA
* signal cascode itself.  Its diode-connected cascode therefore generates
* vpc from MOS VSG values instead of an IR level shift.
XMPCBIAS vpc iref vss vss sky130_fd_pr__nfet_01v8 l=1 w=8 nf=2
XMPCSOURCE pcs vbp vdd vdd sky130_fd_pr__pfet_01v8 l=1 w=16 nf=4
XMPCDIO vpc vpc pcs vdd sky130_fd_pr__pfet_01v8 l=0.25 w=24 nf=6

* Low-voltage NMOS cascode replica.  The lower device copies the 25 uA
* sink current density and the upper diode copies the signal cascode.
* Finite output resistance places ncs close to the lower device's
* saturation boundary, producing the standard wide-swing cascode rail.
XMNCSOURCE ncs iref vss vss sky130_fd_pr__nfet_01v8 l=1 w=8 nf=2
XMNCDIO vcn vcn ncs vss sky130_fd_pr__nfet_01v8 l=0.25 w=4 nf=1
XMNCLOAD vcn vbp vdd vdd sky130_fd_pr__pfet_01v8 l=1 w=16 nf=4

* The high-current second-stage load has its own same-L replica.  A 50 uA
* diode of 12 um at L=0.5 is mirrored 16:1 by each 192 um output load.
XMOBIASN vbpout iref vss vss sky130_fd_pr__nfet_01v8 l=1 w=16 nf=4
XMOBIASP vbpout vbpout vdd vdd sky130_fd_pr__pfet_01v8 l=0.5 w=12 nf=3

* Dedicated long-channel tail-current replica.  XTAILBIAS copies the 50 uA
* PMOS bias branch without disturbing the global iref node; XTAILREF then
* establishes the VGS for the 3:1 long-channel tail mirror.
XMTAILBIAS tailbias vbp vdd vdd sky130_fd_pr__pfet_01v8 l=1 w=32 nf=8
XMTAILREF tailbias tailbias vss vss sky130_fd_pr__nfet_01v8 l=4 w=64 nf=4

* Dedicated long-channel replica for the 100 uA first-stage PMOS sources.
* A 50 uA diode branch sets vbpsrc; each main source mirrors it 2:1.
XMFSBIASN vbpsrc iref vss vss sky130_fd_pr__nfet_01v8 l=1 w=16 nf=4
XMFSBIASP vbpsrc vbpsrc vdd vdd sky130_fd_pr__pfet_01v8 l=4 w=128 nf=16

* -- folded-cascode first stage --
XMTAIL tail tailbias vss vss sky130_fd_pr__nfet_01v8 l=4 w=192 nf=12
XMINP fp vinp tail vss sky130_fd_pr__nfet_01v8 l=1 w=160 nf=32
XMINN fn vinn tail vss sky130_fd_pr__nfet_01v8 l=1 w=160 nf=32
XMSOURCEP fp vbpsrc vdd vdd sky130_fd_pr__pfet_01v8 l=4 w=256 nf=32
XMSOURCEN fn vbpsrc vdd vdd sky130_fd_pr__pfet_01v8 l=4 w=256 nf=32
XMPCASP stagep vpc fp vdd sky130_fd_pr__pfet_01v8 l=0.25 w=24 nf=6
XMPCASN stagen vpc fn vdd sky130_fd_pr__pfet_01v8 l=0.25 w=24 nf=6
XMNCASP stagep vcn sinkp vss sky130_fd_pr__nfet_01v8 l=0.25 w=4 nf=1
XMNCASN stagen vcn sinkn vss sky130_fd_pr__nfet_01v8 l=0.25 w=4 nf=1
XMSINKP sinkp vcmfb vss vss sky130_fd_pr__nfet_01v8 l=3.35 w=26.8 nf=6
XMSINKN sinkn vcmfb vss vss sky130_fd_pr__nfet_01v8 l=3.35 w=26.8 nf=6

* -- symmetric common-source second stage --
XMSECOND_P voutp stagep vss vss sky130_fd_pr__nfet_01v8 l=0.25 w=64 nf=16
XMSECOND_N voutn stagen vss vss sky130_fd_pr__nfet_01v8 l=0.25 w=64 nf=16
XMLOAD_P voutp vbpout vdd vdd sky130_fd_pr__pfet_01v8 l=0.5 w=192 nf=48
XMLOAD_N voutn vbpout vdd vdd sky130_fd_pr__pfet_01v8 l=0.5 w=192 nf=48

* -- symmetric series-RC Miller compensation --
XRZP stagep zp sky130_fd_pr__res_generic_po w=0.33 l=3.41 m=1
CCCP zp voutp sky130_fd_pr__model__cap_mim a=591.9489 p=97.32
XRZN stagen zn sky130_fd_pr__res_generic_po w=0.33 l=3.41 m=1
CCCN zn voutn sky130_fd_pr__model__cap_mim a=591.9489 p=97.32

* -- continuous-time output common-mode feedback --
XRCMP voutp vcms sky130_fd_pr__res_generic_po w=0.33 l=568.46 m=1
XRCMN voutn vcms sky130_fd_pr__res_generic_po w=0.33 l=568.46 m=1
CCCMP voutp vcms sky130_fd_pr__model__cap_mim a=47.7481 p=27.64
CCCMN voutn vcms sky130_fd_pr__model__cap_mim a=47.7481 p=27.64
* Seven-times-strength CMFB core.  All branch currents and device widths are
* scaled together so the bias voltages/current densities remain approximately
* unchanged while the long-channel controlled sinks recover common mode fast.
XMCMTAIL cmtail iref vss vss sky130_fd_pr__nfet_01v8 l=1 w=112 nf=28
XMCMREF cma vocm cmtail vss sky130_fd_pr__nfet_01v8 l=0.5 w=140 nf=35
XMCMSENSE vcmfb vcms cmtail vss sky130_fd_pr__nfet_01v8 l=0.5 w=140 nf=35
XMCMDIO cma cma vdd vdd sky130_fd_pr__pfet_01v8 l=1 w=112 nf=28
XMCMMIRROR vcmfb cma vdd vdd sky130_fd_pr__pfet_01v8 l=1 w=126 nf=56
XMCMNDIO vcmfb vcmfb vss vss sky130_fd_pr__nfet_01v8 l=1 w=14 nf=7
.ends fd_two_stage_miller_opamp
