* Fully-integrated external-capacitor-free LDO: 1.0 V from 1.5-1.8 V,
* 0-20 mA DC and 0.5-20 mA dynamic load.
* Architecture: symmetric current-mirror OTA (lvt-P input pair) directly
* driving a 3 mm std-pfet pass device; Miller Rz/Cm compensation across the pass
* stage; internal 30k/20k feedback divider with lead capacitor; split on-chip
* output capacitance (damped branch + direct branch); supply-independent
* beta-multiplier bias with an always-on high-value starter resistor.
.subckt capless_ldo vin vout vss vref
* bias: beta-multiplier (~8 uA) + starter
XRbs vin nb vss sky130_fd_pr__res_xhigh_po_0p35 l=131.15 m=1
XRda vin sa vss sky130_fd_pr__res_high_po_1p41 l=51.04 m=1
XRdb vin sb vss sky130_fd_pr__res_high_po_1p41 l=51.04 m=1
XMPA  nb   pb   sa  vin sky130_fd_pr__pfet_01v8_lvt  l=1.0 w=22
XMPB  pb   pb   sb  vin sky130_fd_pr__pfet_01v8_lvt  l=1.0 w=22
XMN1  nb   nb   vss vss sky130_fd_pr__nfet_01v8      l=1.0 w=10
XMN2  pb   nb   ns  vss sky130_fd_pr__nfet_01v8      l=1.0 w=40
XRs ns vss vss sky130_fd_pr__res_high_po_1p41 l=32.78 m=1
* error amplifier: symmetric mirror OTA, lvt-P pair, K~3.5 mirrors
XRdt vin st vss sky130_fd_pr__res_high_po_1p41 l=51.04 m=1
XMPT  tail pb   st   vin  sky130_fd_pr__pfet_01v8_lvt l=1.0 w=22
XM1A  d4   vref tail tail sky130_fd_pr__pfet_01v8_lvt l=0.5 w=24
XM1B  d3   fb   tail tail sky130_fd_pr__pfet_01v8_lvt l=0.5 w=24
XM3   d3   d3   vss  vss  sky130_fd_pr__nfet_01v8     l=1.5 w=25
XM4   d4   d4   vss  vss  sky130_fd_pr__nfet_01v8     l=1.5 w=25
XM5   gate d3   vss  vss  sky130_fd_pr__nfet_01v8     l=1.5 w=88
XM6   d7   d4   vss  vss  sky130_fd_pr__nfet_01v8     l=1.5 w=88
XRd7 vin s7 vss sky130_fd_pr__res_high_po_1p41 l=55.39 m=1
XRd8 vin s8 vss sky130_fd_pr__res_high_po_1p41 l=55.39 m=1
XM7   d7   d7   s7   vin  sky130_fd_pr__pfet_01v8_lvt l=1.0 w=22
XM8   gate d7   s8   vin  sky130_fd_pr__pfet_01v8_lvt l=1.0 w=22
* pass device and Miller compensation
XMP   vout gate vin vin sky130_fd_pr__pfet_01v8 l=0.35 w=500 nf=10 m=6
CCm gate cmx sky130_fd_pr__model__cap_mim a=1487.6449 p=154.28
XRz cmx vout vss sky130_fd_pr__res_high_po_1p41 l=8.39 m=1
* internal feedback divider with lead capacitor
XR1 vout fb vss sky130_fd_pr__res_high_po_1p41 l=129.29 m=1
CCf vout fb sky130_fd_pr__model__cap_mim a=1985.5936 p=178.24
XR2 fb vss vss sky130_fd_pr__res_high_po_1p41 l=85.82 m=1
* on-chip output capacitance: damped branch + direct branch (977 pF total)
XResr vout vc1 vss sky130_fd_pr__res_high_po_5p73 l=1.45 m=1
CC1 vc1 vss sky130_fd_pr__model__cap_mim a=424791.0976 p=2607.04
CC2 vout vss sky130_fd_pr__model__cap_mim a=59917.2484 p=979.12
.ends capless_ldo
