* Capless LDO output-window / quiescent-current matrix bench.  One process
* covers the six declared supply/temperature points of one corner.  At each
* point the no-load quiescent current is taken from an operating point reached
* by a transient power-up (optran), and the output-voltage window over the full
* 0-20 mA load range is taken from a slow, quasi-static load ramp that starts
* from that powered-up no-load state.  Directly runnable at tt.
.lib "/opt/analog-layout/pdks/sky130/sky130A/libs.tech/ngspice/sky130.lib.spice" tt
.include "dut.spice"
.options reltol=2e-4 abstol=1e-12 vntol=1e-6 method=gear
VSS vss 0 0
VSUP vin vss 1.5
VREF vref vss 0.4
* Load: ILOAD is the ideal reference current (its value/waveform is the
* commanded load) of a test-bench 1:1 NMOS cascode current mirror.  The two
* stacked diode-connected reference devices set both gate voltages; the matched
* output stack draws the load from vout through the 0 V meter VLMEAS.  Unlike
* an ideal current source, a transistor mirror cannot pull vout below ground,
* which removes the unphysical negative-output DC solution.
ILOAD vss tbld_ref PWL(0 0 20u 0 2020u 20m 2040u 20m)
XTBLD_REFC tbld_ref tbld_ref tbld_g vss sky130_fd_pr__nfet_01v8_lvt l=0.5 w=50 nf=1 m=80 mult=80
XTBLD_REF tbld_g tbld_g vss vss sky130_fd_pr__nfet_01v8_lvt l=0.5 w=50 nf=1 m=80 mult=80
VLMEAS vout tbld_d 0
XTBLD_OUTC tbld_d tbld_ref tbld_m vss sky130_fd_pr__nfet_01v8_lvt l=0.5 w=50 nf=1 m=80 mult=80
XTBLD_OUT tbld_m tbld_g vss vss sky130_fd_pr__nfet_01v8_lvt l=0.5 w=50 nf=1 m=80 mult=80
XDUT vin vout vss vref capless_ldo

.control
set noaskquit
* Operating points from a transient power-up (ngspice 46 optran): skip the
* Newton, gmin-stepping and source-stepping DC attempts and integrate from
* all-zero node voltages with every source at its t=0 value; the final state
* is the operating point.  Gear integration (method=gear in .options) keeps the
* DC branch currents read from that state free of trapezoidal ringing.
optran 0 0 0 1u 1m 0
let supplies = vector(2)
let supplies[0] = 1.5
let supplies[1] = 1.8
let temperatures = vector(3)
let temperatures[0] = -40
let temperatures[1] = 27
let temperatures[2] = 85

set points = ( 4 )
foreach run $points
  let voltage_index = floor($run/3)
  let temperature_index = $run - 3*voltage_index
  let supply = supplies[voltage_index]
  let temperature = temperatures[temperature_index]
  set prefix = m$run
  set temp = $&temperature
  alter VSUP = $&supply

  * no-load VIN current (includes the divider; ideal VREF current is free),
  * excluding the off mirror's leakage drawn through VLMEAS
  op
  let {$prefix}_iq_ua = (abs(i(VSUP))-i(VLMEAS))*1e6
  print {$prefix}_iq_ua

  * output-voltage window over the full 0-20 mA load range
  tran 1u 2040u 0 2u
  meas tran {$prefix}_vmax_v MAX v(vout) from=20u to=2040u
  meas tran {$prefix}_vmin_v MIN v(vout) from=20u to=2040u
  meas tran {$prefix}_iload_end_a FIND i(VLMEAS) AT=2040u
  destroy all
end
quit
.endc
.end
