* Two-stage Monticelli class-AB line driver.
.subckt low_power_line_driver vss iref vdd vinn vinp vout
* Bias network derived from the external 50 uA reference.
XMB0 iref iref vss vss sky130_fd_pr__nfet_01v8 l=0.8 w=120 nf=10
XMBT tail iref vss vss sky130_fd_pr__nfet_01v8 l=0.8 w=48 nf=4
XMB1 pbias iref vss vss sky130_fd_pr__nfet_01v8 l=0.8 w=24 nf=2
XMB2 vbp iref vss vss sky130_fd_pr__nfet_01v8 l=0.8 w=12 nf=1
XMPB0 pbias pbias vdd vdd sky130_fd_pr__pfet_01v8 l=0.8 w=51.2 nf=4
XMPB1 vbn pbias vdd vdd sky130_fd_pr__pfet_01v8 l=0.8 w=25.6 nf=2
XMNT2 vbn vbn midn vss sky130_fd_pr__nfet_01v8 l=0.3 w=3.8 nf=1
XMNT1 midn midn vss vss sky130_fd_pr__nfet_01v8 l=0.3 w=5.8 nf=1
XMPT1 midp midp vdd vdd sky130_fd_pr__pfet_01v8 l=0.3 w=25.2 nf=2
XRSH midp vbp sky130_fd_pr__res_generic_po w=0.33 l=568.46 m=1
* First stage.
XM1 x3 vinp tail vss sky130_fd_pr__nfet_01v8 l=0.5 w=30 nf=2
XM2 x5 vinn tail vss sky130_fd_pr__nfet_01v8 l=0.5 w=30 nf=2
XMP3 x3 x3 vdd vdd sky130_fd_pr__pfet_01v8 l=0.8 w=51.2 nf=4
XMP4 x4 x3 vdd vdd sky130_fd_pr__pfet_01v8 l=0.8 w=51.2 nf=4
XMP5 x5 x5 vdd vdd sky130_fd_pr__pfet_01v8 l=0.8 w=51.2 nf=4
XMP6 gp x5 vdd vdd sky130_fd_pr__pfet_01v8 l=0.8 w=51.2 nf=4
XMN7 x4 x4 vss vss sky130_fd_pr__nfet_01v8 l=0.8 w=24 nf=2
XMN8 gn x4 vss vss sky130_fd_pr__nfet_01v8 l=0.8 w=24 nf=2
* Floating complementary Monticelli control between output gates.
XMCN gp vbn gn vss sky130_fd_pr__nfet_01v8 l=0.3 w=7.6 nf=1
XMCP gn vbp gp vdd sky130_fd_pr__pfet_01v8 l=0.3 w=7.6 nf=1
XRBAT gp gn sky130_fd_pr__res_generic_po w=0.33 l=11369.29 m=1
* Complementary common-source output pair and compensation.
XMPO vout gp vdd vdd sky130_fd_pr__pfet_01v8 l=0.3 w=252 nf=18
XMNO vout gn vss vss sky130_fd_pr__nfet_01v8 l=0.3 w=48 nf=4
CCC1 vout cz1 sky130_fd_pr__model__cap_mim a=740.9284 p=108.88
XRZ1 cz1 gn sky130_fd_pr__res_generic_po w=0.33 l=3.87 m=1
CCC2 vout cz2 sky130_fd_pr__model__cap_mim a=740.9284 p=108.88
XRZ2 cz2 gp sky130_fd_pr__res_generic_po w=0.33 l=3.87 m=1
.ends low_power_line_driver
